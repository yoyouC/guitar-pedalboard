WDF JC-120 参考电路(L4 评测:全固态清音链,无电子管)
* 与 src/audio/wdf/jc120Core.ts 同构:30Hz 输入 HP → 运放增益级
* (15V 轨 tanh 软饱和)→ 后级 x2(25V 深度 tanh)→ 扬声器 50Hz HP + 8kHz LP。
* 首行为标题。tanh 为平滑函数(不用 max() 硬折线,§4.5)。
* 级间单位增益缓冲隔离,消除集总滤波器负载效应(§4.5)。

* --- 电源与输入(50mV 1kHz,相位 90 = cos,对齐 WDF 侧) ---
Vin vin 0 SIN(0 0.05 1000 0 0 90)

* 输入耦合 HP 30Hz(53.05n x 100k)
Cin vin hpin 53.05n
Rin hpin 0 100k
Ein hpinb 0 hpin 0 1

* --- 运放线性增益级:xdrive(gain=40 -> 9.2),15V 轨软饱和 ---
Epre pre 0 hpinb 0 9.2
B1 prer 0 V = 15*tanh(v(pre)/15)

* --- 固态后级:x2,25V 深度 tanh 兜底 ---
Epa pa 0 prer 0 2
B2 par 0 V = 25*tanh(v(pa)/25)

* --- 扬声器:50Hz HP(31.83n x 100k)→ 缓冲 → 8kHz LP(1k x 19.894n) ---
Csp par sph 31.83n
Rsp sph 0 100k
Esp sphb 0 sph 0 1
Rlp sphb out 1k
Clp out 0 19.894n
Rl out 0 1Meg

.tran 20.8333u 185.33m 100m 20.8333u
.print tran v(out)
.end
