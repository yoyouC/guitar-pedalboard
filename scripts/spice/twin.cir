WDF Twin 参考电路(L4 评测:2x12AX7 + 阴极跟随器 + 6L6 后级)
* 与 src/audio/wdf/twinWorklet.ts 同构:volume 在级1/级2之间(分压 RA1/RB1,
* 默认 GAIN=50 档 vol=0.125),CF 栅极漏电阻接到 95V 偏置轨(交流接地),
* 60Hz/5.5kHz 输出变压器,级间单位增益缓冲。首行为标题。

* --- Koren 三极管子电路(12AX7:mu=100 ex=1.4 kg=1060 kp=600 kvb=300) ---
.subckt T12AX7 a g k
B1 a k I = (max((max(v(a,k),0)/600)*(log(1+exp(-abs(600*(0.01+v(g,k)/sqrt(300+v(a,k)*v(a,k))))))+max(600*(0.01+v(g,k)/sqrt(300+v(a,k)*v(a,k))),0)),0))**1.4/1060
Dg g cn DGRID
Rc cn k 1000
.ends

* --- Koren 6L6 近似(mu=8.2 ex=1.35 kg=1030 kp=42 kvb=1200) ---
.subckt T6L6 a g k
B1 a k I = (max((max(v(a,k),0)/42)*(log(1+exp(-abs(42*(0.1219512+v(g,k)/sqrt(1200+v(a,k)*v(a,k))))))+max(42*(0.1219512+v(g,k)/sqrt(1200+v(a,k)*v(a,k))),0)),0))**1.35/1030
Dg g cn DGRID
Rc cn k 1000
.ends

.model DGRID D(IS=1e-9 N=1.6)

* --- 电源与输入 ---
Vb b 0 300
Vbp bp 0 420
Vbias vb 0 95
Vin vin 0 SIN(0 0.05 1000 0 0 90)

* --- 级1:12AX7,Rk 1.5k + Ck 25u 全旁路,Rs 34k ---
Rg1 vin g1 34k
Rp1 b p1 100k
X1 p1 g1 k1 T12AX7
Rk1 k1 0 1.5k
Ck1 k1 0 25u

* 耦合 + volume(GAIN=50:vol=0.4·(50/100)^2=0.1,900k/100k,Thevenin 90k≈WDF Rs 100k)
Co1 p1 g2a 22n
Ra1 g2a g2 900k
Rb1 g2 0 100k

* --- 级2:12AX7,Rk 1.5k + Ck 25u 全旁路 ---
Rp2 b p2 100k
X2 p2 g2 k2 T12AX7
Rk2 k2 0 1.5k
Ck2 k2 0 25u

* 耦合 → 阴极跟随器(栅漏 1M 接 95V 偏置轨;Rs 47k 栅流路径)
Co2 p2 g3a 22n
Rl3 g3a vb 1Meg
Rg3 g3a g3 47k

* --- 阴极跟随器:板极直连 B+,Rk 100k,阴极输出 ---
X3 b g3 k3 T12AX7
Rk3 k3 0 100k

* 耦合 + 后级驱动衰减 0.6(380k/570k,Thevenin 228k≈WDF Rs 220k)
Co3 k3 cfo 22n
Rcf cfo 0 1Meg
Ra4 cfo g4 380k
Rb4 g4 0 570k

* --- 6L6 后级:B+ 420V,Rp 2k(反射负载),Rk 250 ---
Rp4 bp p4 2k
X4 p4 g4 k4 T6L6
Rk4 k4 0 250

* --- 输出变压器:60Hz HP(26.5n×100k)→ 缓冲 → 5.5kHz LP(1k×28.9n) ---
Ctx p4 tx 26.5n
Rtx tx 0 100k
Ebuf txb 0 tx 0 1
Rlp txb out 1k
Clp out 0 28.9n
Rl out 0 1Meg

.tran 20.8333u 185.33m 100m 20.8333u
.print tran v(p1) v(p2) v(k3) v(p4) v(tx) v(out)
.end
