* Big Muff Pi(V3)WDF 参考电路(L4 评测用,sustain=0.5, tone=0.5)
* 与 src/audio/wdf/bigmuff.ts 同构:理想反相增益块(ngspice 2N5088 小信号
* 校准:A1=16, A2=42)+ 戴维南电阻 + 反并联 1N4148 对地削波 + 无源 TONE
* 交叉淡化。所有集总滤波节间用单位增益缓冲隔离(与 WDF 一阶节一致)。
* 运行: ngspice -b bigmuff.cir

* 输入:50mV / 1kHz 正弦(与 WDF 评测一致)
Vin in 0 SIN(0 0.05 1000 0 0 90)

* SUSTAIN 分压 k=0.5
Esus sus 0 in 0 0.5

* 输入耦合 HP 90Hz(C3 100n)
C3 sus hp1 100n
Rh1 hp1 0 17.68k
Eb1 b1 0 hp1 0 1

* 削波级 1:A1=16 反相 + Rth1=6.9k + D1/D2 对地
E1 th1 0 b1 0 -16
Rt1 th1 c1 6.9k
D1 c1 0 D1N4148
D2 0 c1 D1N4148

* 级间耦合 HP 155Hz(C13 100n)
Eb2 b2 0 c1 0 1
C13 b2 hp2 100n
Rh2 hp2 0 10.27k
Eb3 b3 0 hp2 0 1

* 级2 输入 Miller 加载极点 LP 920Hz(1.73k x 100n = 919.6Hz)
Rl b3 lp2 1.73k
Cl lp2 0 100n
Eb4 b4 0 lp2 0 1

* 削波级 2:A2=42 反相 + Rth2=9.8k + D3/D4 对地
E2 th2 0 b4 0 -42
Rt2 th2 c2 9.8k
D3 c2 0 D1N4148
D4 0 c2 D1N4148

* 输出耦合 C7 1u + 级2 输出阻抗 Rsrc=10k(→ HP ~3.2Hz)
Eb5 b5 0 c2 0 1
Rsrc b5 n7 10k
C7 n7 s 1u

* TONE 交叉淡化(tone=0.5):LP 臂 R8 39k + C8 10n;HP 臂 C9 4n + R5 22k
R8 s a 39k
C8 a 0 10n
C9 s b 4n
R5 b 0 22k
Rp1 a out 50k
Rp2 out b 50k

.model D1N4148 D(IS=2.52e-9 N=1.752 RS=0.5)

* 瞬态:500ms 建立舍去(最慢极点 3.2Hz,tau≈50ms,10τ),记录后 100ms @48kHz
.tran 20.8333u 600m 500m 20.8333u
.print tran v(out) v(in)
.end
