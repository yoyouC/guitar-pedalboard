WDF AC30 参考电路(L4 评测:2x12AX7 + 阴极跟随器 + EL84 A 类 + 变压器/临场峰)
* 与 src/audio/wdf/ac30Core.dsp.js 同构:60Hz 输入 HP、级间分压、
* CF 栅漏 +60V 偏置、75Hz/5.5kHz 输出变压器、2.5kHz 串联 RLC 临场峰支路。
* 音色栈在 WDF 侧为 RBJ 双二阶,50=平直=精确直通,故网表略去(对比取全 50)。
* 首行为标题(ngspice 跳过)。

* --- Koren 三极管子电路(12AX7:mu=100 ex=1.4 kg=1060 kp=600 kvb=300) ---
.subckt T12AX7 a g k
B1 a k I = (max((max(v(a,k),0)/600)*(log(1+exp(-abs(600*(0.01+v(g,k)/sqrt(300+v(a,k)*v(a,k))))))+max(600*(0.01+v(g,k)/sqrt(300+v(a,k)*v(a,k))),0)),0))**1.4/1060
Dg g cn DGRID
Rc cn k 1000
.ends

* --- Koren EL84 近似(mu=19 ex=1.35 kg=210 kp=60 kvb=500;kg 按静态 35mA 标定) ---
.subckt TEL84 a g k
B1 a k I = (max((max(v(a,k),0)/60)*(log(1+exp(-abs(60*(0.05263+v(g,k)/sqrt(500+v(a,k)*v(a,k))))))+max(60*(0.05263+v(g,k)/sqrt(500+v(a,k)*v(a,k))),0)),0))**1.35/210
Dg g cn DGRID
Rc cn k 1000
.ends

.model DGRID D(IS=1e-9 N=1.6)

* --- 电源与输入 ---
Vb b 0 300
Vbp bp 0 310
Vcf cfb 0 60
Vin vin 0 SIN(0 0.05 1000 0 0 90)

* 输入 HP 60Hz(26.5n × 100k)
Cin vin hpin 26.5n
Rin hpin 0 100k

* --- 级1:12AX7 暖偏置,Rk 1.5k + Ck 22u 全旁路,Rs 68k ---
Rg1 hpin g1 68k
Rp1 b p1 100k
X1 p1 g1 k1 T12AX7
Rk1 k1 0 1.5k
Ck1 k1 0 22u

* 耦合 + 级间衰减 0.025(975k/25k,戴维南 24.4k = 级2 Rs)
Co1 p1 g2a 4.7n
Ra1 g2a g2 975k
Rb1 g2 0 25k

* --- 级2:12AX7 冷一点,Rk 2.7k + Ck 0.68u 部分旁路 ---
Rp2 b p2 100k
X2 p2 g2 k2 T12AX7
Rk2 k2 0 2.7k
Ck2 k2 0 0.68u

* 耦合 + 级间衰减 0.075(925k/75k,戴维南 69.4k = CF Rs);Rb2 接 +60V 偏置源
Co2 p2 g3a 4.7n
Ra2 g3a g3 925k
Rb2 g3 cfb 75k

* --- 阴极跟随器:板极直连 B+,Rk 100k,输出取自阴极 ---
X3 b g3 k3 T12AX7
Rk3 k3 0 100k

* 耦合 + EL84 栅路:220k 栅阻 + 1M 栅漏(衰减 0.8197,负载 1.22M,Rs 220k)
Co3 k3 g4a 4.7n
Rgp g4a g4 220k
Rgl g4 0 1Meg

* --- EL84 后级:A 类,B+ 310V,Rp 4k(反射负载),Rk 150 热偏置 ---
Rp4 bp p4 4k
X4 p4 g4 k4 TEL84
Rk4 k4 0 150

* --- 输出变压器:75Hz HP(21.2n×100k)→ 缓冲 → 5.5kHz LP(1k×28.9n)
Ctx p4 tx 21.2n
Rtx tx 0 100k
Ebuf txb 0 tx 0 1
Rlp txb lpo 1k
Clp lpo 0 28.9n

* --- 临场峰支路:串联 RLC(63.7m/63.7n/1k,f0=2.5kHz Q=1)取 R 上电压,0.45 叠加 ---
Lbp txb b1 63.7m
Cbp b1 bpo 63.7n
Rbp bpo 0 1k
Rdc b1 0 100Meg
Bsum out 0 V = v(lpo) + 0.45*v(bpo)
Rl out 0 1Meg

* 建立期 450ms:临场峰 LC 储能 τ=2L/R≈127ms,250ms 时振铃残余 ~13%
* (v(k3) 逐周期抖动 ~5-10%,污染 THD/RMSE 测量),450ms ≈ 3.5τ 后 <3%。
.tran 20.8333u 535.33m 450m 20.8333u
.print tran v(p1) v(p2) v(k3) v(p4) v(out)
.end
